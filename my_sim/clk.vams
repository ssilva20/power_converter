//Verilog-AMS HDL for "Silva_Buck", "clk" "verilogams"

`include "constants.vams"
`include "disciplines.vams"

`timescale 1ns/1ps
module clk (clk, rst);
	output clk, rst;
	reg clk, rst;

	parameter real CLK_PERIOD = 1000; // 1MHz -> 1000 ns

	initial begin
		clk = 1;
		rst = 0;
	end

	always #(CLK_PERIOD/2) clk = ~clk;

endmodule
